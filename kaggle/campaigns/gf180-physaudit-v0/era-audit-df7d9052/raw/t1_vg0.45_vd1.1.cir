* physaudit T1 sp vgs=0.45 vds=1.1 w=2e-05
.include "/home/dpatni/circuit-repro/.env/pdks/gf180mcu/models/ngspice/design.ngspice"
.lib "/home/dpatni/circuit-repro/.env/pdks/gf180mcu/models/ngspice/sm141064.ngspice" typical
Vg gb 0 dc 0.45
Lg gb g 1
Vd db 0 dc 1.1
Ld db d 1
Vp1 p1 0 dc 0 ac 1 portnum 1 z0 50
Cp1 p1 g 1
Vp2 p2 0 dc 0 ac 0 portnum 2 z0 50
Cp2 p2 d 1
X1 d g 0 0 nmos_3p3 w=2e-05 l=0.28e-6 nf=10
.control
op
let id = -i(Vd)
print id
sp dec 20 1e8 5e11 0
set wr_singlescale
set wr_vecnames
let s11r=real(S_1_1)
let s11i=imag(S_1_1)
let s12r=real(S_1_2)
let s12i=imag(S_1_2)
let s21r=real(S_2_1)
let s21i=imag(S_2_1)
let s22r=real(S_2_2)
let s22i=imag(S_2_2)
wrdata t1_vg0.45_vd1.1_sp.csv s11r s11i s12r s12i s21r s21i s22r s22i
.endc
.end
