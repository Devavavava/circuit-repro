* Auto-generated from an AnalogGenie topology by lna/to_spice.py
* Device values are placeholders exposed as .param for a sizing loop.

.include C:/Users/Devavrat/circuit-repro/.claude/worktrees/lna-data/AutoCkt/repo/eval_engines/ngspice/ngspice_inputs/spice_models/45nm_bulk.txt

.param pVDD=1.1 pVB=0.5
.param pINDQ=12.0 pINDW0=1.25664e+10
.param pC1V=1p
.param pC2V=1p
.param pC3V=1p
.param pC4V=1p
.param pC5V=1p
.param pNM1W=40u pNM1L=45n
.param pNM2W=40u pNM2L=45n
.param pR1V=1k
.param pR10V=1k
.param pR11V=1k
.param pR12V=1k
.param pR2V=1k
.param pR3V=1k
.param pR4V=1k
.param pR5V=1k
.param pR6V=1k
.param pR7V=1k
.param pR8V=1k
.param pR9V=1k

Vsup VDD 0 dc {pVDD}

* port 1: RF input, DC-blocked so bias is not shorted to 50 ohm
Vp1 p1 0 dc 0 ac 1 portnum 1 z0 50
Cp1 p1 VIN1 10p
* port 2: RF output
Cp2 VOUT1 p2 10p
Vp2 p2 0 dc 0 ac 0 portnum 2 z0 50

CC1 n2 0 {pC1V}
CC2 n2 0 {pC2V}
CC3 n2 0 {pC3V}
CC4 n2 0 {pC4V}
CC5 VIN1 n1 {pC5V}
MNM1 VOUT1 n1 0 0 nmos W={pNM1W} L={pNM1L}
MNM2 VOUT2 n2 VIN1 0 nmos W={pNM2W} L={pNM2L}
RR1 n1 n11 {pR1V}
RR10 n9 n5 {pR10V}
RR11 n7 VOUT2 {pR11V}
RR12 VDD n4 {pR12V}
RR2 n2 n10 {pR2V}
RR3 n8 n0 {pR3V}
RR4 VDD n3 {pR4V}
RR5 n3 n8 {pR5V}
RR6 n5 n7 {pR6V}
RR7 n4 VOUT1 {pR7V}
RR8 n6 n9 {pR8V}
RR9 n0 n6 {pR9V}

* Dataset topologies are textbook schematics: they show the signal path
* but omit biasing, so nodes reachable only through capacitors have no
* DC path and the OP solve goes singular. rshunt ties every node to
* ground through 1e12 ohm -- enough for a DC solution, negligible at RF.
* Without it, 9 of 26 dataset LNAs fail to simulate at all.
.option rshunt=1e12
.control
op
sp lin 201 1e+09 4e+09 1
let s11db = db(mag(S_1_1) + 1e-30)
let s21db = db(mag(S_2_1) + 1e-30)
print vecmin(s11db) vecmax(s21db)
noise v(p2) Vp1 dec 20 1e+09 4e+09 1
.endc
.end
