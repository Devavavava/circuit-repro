* Auto-generated by lna/data/external/_tools/to_spice_bjt_ext.py
* Extends lna/to_spice.py's approach with NPN/PNP support (see module docstring).

.include C:/Users/Devavrat/circuit-repro/.claude/worktrees/lna-data/AutoCkt/repo/eval_engines/ngspice/ngspice_inputs/spice_models/45nm_bulk.txt
.model qnpn npn(bf=100 is=1e-16 vaf=50 rb=50 re=1 tf=10p cjc=20f cje=20f)
.model qpnp pnp(bf=50 is=1e-16 vaf=50 rb=50 re=1 tf=20p cjc=20f cje=20f)

.param pVDD=1.1 pVB=0.5
.param pINDQ=12.0 pINDW0=1.25664e+10
.param pC1V=1p
.param pC2V=1p
.param pL1V=1n
.param pL2V=1n
.param pL3V=1n
.param pNM1W=40u pNM1L=45n
.param pR1V=1k
.param pR2V=1k
.param pR3V=1k

Vsup VDD 0 dc {pVDD}

Vp1 p1 0 dc 0 ac 1 portnum 1 z0 50
Cp1 p1 VIN1 10p
Cp2 VOUT1 p2 10p
Vp2 p2 0 dc 0 ac 0 portnum 2 z0 50

CC1 n1 n3 {pC1V}
CC2 n1 n3 {pC2V}
LL1 VDD nqL1 {pL1V}
RQL1 nqL1 VOUT1 {pINDW0*pL1V/pINDQ}
LL2 n0 nqL2 {pL2V}
RQL2 nqL2 0 {pINDW0*pL2V/pINDQ}
LL3 n3 nqL3 {pL3V}
RQL3 nqL3 n5 {pINDW0*pL3V/pINDQ}
MNM1 n2 n2 0 0 nmos W={pNM1W} L={pNM1L}
QNPN1 VOUT1 VDD n4 qnpn
QNPN10 n4 n5 n0 qnpn
QNPN11 VOUT1 VDD n4 qnpn
QNPN12 n4 n5 n0 qnpn
QNPN2 n4 n5 n0 qnpn
QNPN3 VOUT1 VDD n4 qnpn
QNPN4 n4 n5 n0 qnpn
QNPN5 VOUT1 VDD n4 qnpn
QNPN6 n4 n5 n0 qnpn
QNPN7 VOUT1 VDD n4 qnpn
QNPN8 n4 n5 n0 qnpn
QNPN9 VOUT1 VDD n4 qnpn
RR1 n3 n2 {pR1V}
RR2 n2 VDD {pR2V}
RR3 n1 VIN1 {pR3V}

.option rshunt=1e12
.control
op
sp lin 201 1e+09 4e+09 1
let s11db = db(mag(S_1_1) + 1e-30)
let s21db = db(mag(S_2_1) + 1e-30)
print vecmin(s11db) vecmax(s21db)
noise v(p2) Vp1 dec 20 1e+09 4e+09 1
.endc
.end
