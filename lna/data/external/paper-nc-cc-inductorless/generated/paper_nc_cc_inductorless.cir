* Auto-generated from an AnalogGenie topology by lna/to_spice.py
* Device values are placeholders exposed as .param for a sizing loop.

.include /home/dpatni/.claude/jobs/a8f610e5/tmp/wt-ext2b/AutoCkt/repo/eval_engines/ngspice/ngspice_inputs/spice_models/45nm_bulk.txt

.param pVDD=1.1 pVB=0.5
.param pINDQ=12 pINDW0=1.25664e+10
.param pC1V=1p
.param pNM1W=40u pNM1L=45n
.param pNM10W=40u pNM10L=45n
.param pNM11W=40u pNM11L=45n
.param pNM12W=40u pNM12L=45n
.param pNM13W=40u pNM13L=45n
.param pNM14W=40u pNM14L=45n
.param pNM15W=40u pNM15L=45n
.param pNM16W=40u pNM16L=45n
.param pNM2W=40u pNM2L=45n
.param pNM3W=40u pNM3L=45n
.param pNM4W=40u pNM4L=45n
.param pNM5W=40u pNM5L=45n
.param pNM6W=40u pNM6L=45n
.param pNM7W=40u pNM7L=45n
.param pNM8W=40u pNM8L=45n
.param pNM9W=40u pNM9L=45n
.param pR1V=1k

Vsup VDD 0 dc {pVDD}
VVB1 VB1 0 dc {pVB}

* port 1: RF input, DC-blocked so bias is not shorted to 50 ohm
Vp1 p1 0 dc 0 ac 1 portnum 1 z0 50
Cp1 p1 VIN1 10p
* port 2: RF output
Cp2 VOUT1 p2 10p
Vp2 p2 0 dc 0 ac 0 portnum 2 z0 50

CC1 VIN1 n0 {pC1V}
MNM1 n3 VB1 n0 0 nmos W={pNM1W} L={pNM1L} NF={max(1,ceil(pNM1W/2e-06))}
MNM10 n1 n1 VDD VDD nmos W={pNM10W} L={pNM10L} NF={max(1,ceil(pNM10W/2e-06))}
MNM11 VB1 n1 VDD VDD nmos W={pNM11W} L={pNM11L} NF={max(1,ceil(pNM11W/2e-06))}
MNM12 VB1 VB1 0 0 nmos W={pNM12W} L={pNM12L} NF={max(1,ceil(pNM12W/2e-06))}
MNM13 n2 n1 VDD VDD nmos W={pNM13W} L={pNM13L} NF={max(1,ceil(pNM13W/2e-06))}
MNM14 n1 n2 0 0 nmos W={pNM14W} L={pNM14L} NF={max(1,ceil(pNM14W/2e-06))}
MNM15 n0 VB1 VDD VDD nmos W={pNM15W} L={pNM15L} NF={max(1,ceil(pNM15W/2e-06))}
MNM16 n3 VB1 VDD VDD nmos W={pNM16W} L={pNM16L} NF={max(1,ceil(pNM16W/2e-06))}
MNM2 VDD n3 n0 0 nmos W={pNM2W} L={pNM2L} NF={max(1,ceil(pNM2W/2e-06))}
MNM3 VOUT1 n0 0 0 nmos W={pNM3W} L={pNM3L} NF={max(1,ceil(pNM3W/2e-06))}
MNM4 VOUT1 n3 0 0 nmos W={pNM4W} L={pNM4L} NF={max(1,ceil(pNM4W/2e-06))}
MNM5 n3 VOUT1 n0 0 nmos W={pNM5W} L={pNM5L} NF={max(1,ceil(pNM5W/2e-06))}
MNM6 n0 n2 0 0 nmos W={pNM6W} L={pNM6L} NF={max(1,ceil(pNM6W/2e-06))}
MNM7 n3 n2 0 0 nmos W={pNM7W} L={pNM7L} NF={max(1,ceil(pNM7W/2e-06))}
MNM8 VOUT1 n2 0 0 nmos W={pNM8W} L={pNM8L} NF={max(1,ceil(pNM8W/2e-06))}
MNM9 n2 n2 0 0 nmos W={pNM9W} L={pNM9L} NF={max(1,ceil(pNM9W/2e-06))}
RR1 VOUT1 VDD {pR1V}

* Dataset topologies are textbook schematics: they show the signal path
* but omit biasing, so nodes reachable only through capacitors have no
* DC path and the OP solve goes singular. rshunt ties every node to
* ground through 1e12 ohm -- enough for a DC solution, negligible at RF.
* Without it, 9 of 26 dataset LNAs fail to simulate at all.
.option rshunt=1e12
.control
op
sp lin 201 1e+09 4e+09 1
let s11db = db(mag(S_1_1) + 1e-30)
let s21db = db(mag(S_2_1) + 1e-30)
print vecmin(s11db) vecmax(s21db)
noise v(p2) Vp1 dec 20 1e+09 4e+09 1
.endc
.end
